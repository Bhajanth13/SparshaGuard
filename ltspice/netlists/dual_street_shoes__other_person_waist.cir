* SparshaGuard v0.3 | dual | street_shoes | other_person waist | bench=False
* nodes: S sense, B her body, A other person, E surroundings, 0 watch ground
V1 drv 0 AC 1
R1 drv n1 1.000000e+04 ; Rs
L2 n1 S 1.000000e-02 ; tank inductor
C3 S 0 1.045000e-10 ; tank C + buffer/trace parasitics
* CPE Q=4.2894e-07 alpha=0.550 metal contact
R7 S x6 3.961284e+06
C8 x6 x4 2.737269e-07
R10 S x9 3.540280e+06
C11 x9 x4 2.086648e-07
R13 S x12 1.198970e+07
C14 x12 x4 1.327431e-08
R16 S x15 2.251156e+06
C17 x15 x4 4.816680e-08
R19 S x18 5.528439e+07
C20 x18 x4 1.336239e-09
R22 S x21 2.920103e+06
C23 x21 x4 1.723542e-08
R25 S x24 3.200242e+06
C26 x24 x4 1.071447e-08
R28 S x27 2.426108e+06
C29 x27 x4 9.628899e-09
R31 S x30 1.984652e+06
C32 x30 x4 8.019285e-09
R34 S x33 1.604297e+06
C35 x33 x4 6.758788e-09
R37 S x36 1.299485e+06
C38 x36 x4 5.684805e-09
R40 S x39 1.052103e+06
C41 x39 x4 4.783676e-09
R43 S x42 8.519455e+05
C44 x42 x4 4.024775e-09
R46 S x45 6.898161e+05
C47 x45 x4 3.386519e-09
R49 S x48 5.585671e+05
C50 x48 x4 2.849343e-09
R52 S x51 4.522736e+05
C53 x51 x4 2.397465e-09
R55 S x54 3.662197e+05
C56 x54 x4 2.017182e-09
R58 S x57 2.965293e+05
C59 x57 x4 1.697276e-09
R61 S x60 2.401093e+05
C62 x60 x4 1.428053e-09
R64 S x63 1.944166e+05
C65 x63 x4 1.201582e-09
R67 S x66 1.574262e+05
C68 x66 x4 1.010981e-09
R70 S x69 1.274671e+05
C71 x69 x4 8.506586e-10
R73 S x72 1.032158e+05
C74 x72 x4 7.157161e-10
R76 S x75 8.357224e+04
C77 x75 x4 6.022241e-10
R79 S x78 6.767311e+04
C80 x78 x4 5.066842e-10
R82 S x81 5.479293e+04
C83 x81 x4 4.263461e-10
R85 S x84 4.436984e+04
C86 x84 x4 3.587007e-10
R88 S x87 3.592402e+04
C89 x87 x4 3.018343e-10
R91 S x90 2.909123e+04
C92 x90 x4 2.539362e-10
R94 S x93 2.355279e+04
C95 x93 x4 2.136868e-10
R97 S x96 1.907392e+04
C98 x96 x4 1.797685e-10
R100 S x99 1.544171e+04
C101 x99 x4 1.512834e-10
R103 S x102 1.250613e+04
C104 x102 x4 1.272615e-10
R106 S x105 1.012377e+04
C107 x105 x4 1.071054e-10
R109 S x108 8.200000e+03
C110 x108 x4 9.008924e-11
R112 S x111 6.637121e+03
C113 x111 x4 7.582989e-11
R115 S x114 5.376702e+03
C116 x114 x4 6.377309e-11
R118 S x117 4.351144e+03
C119 x117 x4 5.368876e-11
R121 S x120 3.525614e+03
C122 x120 x4 4.514247e-11
R124 S x123 2.852377e+03
C125 x123 x4 3.801426e-11
R127 S x126 2.311949e+03
C128 x126 x4 3.195277e-11
R130 S x129 1.869736e+03
C131 x129 x4 2.691782e-11
R133 S x132 1.516207e+03
C134 x132 x4 2.261492e-11
R136 S x135 1.225488e+03
C137 x135 x4 1.906241e-11
R139 S x138 9.944741e+02
C140 x138 x4 1.600393e-11
R142 S x141 8.031032e+02
C143 x141 x4 1.350150e-11
R145 S x144 6.523900e+02
C146 x144 x4 1.132347e-11
R148 S x147 5.261973e+02
C149 x147 x4 9.564703e-12
R151 S x150 4.280423e+02
C152 x150 x4 8.010631e-12
R154 S x153 3.448148e+02
C155 x153 x4 6.774869e-12
R157 S x156 2.804654e+02
C158 x156 x4 5.674673e-12
R160 S x159 2.273532e+02
C161 x159 x4 4.769276e-12
R163 S x162 1.792005e+02
C164 x162 x4 4.122375e-12
R166 S x165 1.667349e+02
C167 x165 x4 3.018517e-12
R169 S x168 8.658586e+01
C170 x168 x4 3.960103e-12
R172 S x171 3.392456e+01
C173 x171 x4 4.691438e-12
R175 S x174 6.171394e+01
C176 x174 x4 1.756994e-12
R178 S x177 2.029061e+00
C179 x177 x4 7.843774e-12
R180 x4 x5 1.460593e+06 ; stratum corneum, 3 cm^2
* CPE Q=2.6478e-07 alpha=0.900 stratum corneum
R182 x4 x181 1.517170e+07
C183 x181 x5 1.539758e-08
R185 x4 x184 3.675989e+06
C186 x184 x5 4.329582e-08
R188 x4 x187 1.812755e+06
C189 x187 x5 1.891535e-08
R191 x4 x190 1.524655e+08
C192 x190 x5 1.532200e-10
R194 x4 x193 1.709618e+06
C195 x193 x5 9.309387e-09
R197 x4 x196 2.034262e+06
C198 x196 x5 5.330237e-09
R200 x4 x199 1.126866e+06
C201 x199 x5 6.555632e-09
R203 x4 x202 8.885546e+05
C204 x202 x5 5.664166e-09
R206 x4 x205 5.906961e+05
C207 x205 x5 5.804828e-09
R209 x4 x208 4.364766e+05
C210 x208 x5 5.352120e-09
R212 x4 x211 2.985266e+05
C213 x211 x5 5.331348e-09
R215 x4 x214 2.180117e+05
C216 x214 x5 4.973633e-09
R218 x4 x217 1.496871e+05
C219 x217 x5 4.935172e-09
R221 x4 x220 1.094299e+05
C222 x220 x5 4.599219e-09
R224 x4 x223 7.479377e+04
C225 x223 x5 4.584458e-09
R227 x4 x226 5.510281e+04
C228 x226 x5 4.239485e-09
R230 x4 x229 3.725931e+04
C231 x229 x5 4.271548e-09
R233 x4 x232 2.784286e+04
C234 x232 x5 3.894391e-09
R236 x4 x235 1.849394e+04
C237 x235 x5 3.994454e-09
R239 x4 x238 1.413420e+04
C240 x238 x5 3.560811e-09
R242 x4 x241 9.135044e+03
C243 x241 x5 3.753555e-09
R245 x4 x244 7.223529e+03
C246 x244 x5 3.233980e-09
R248 x4 x247 4.482004e+03
C249 x247 x5 3.550977e-09
R251 x4 x250 3.729129e+03
C252 x250 x5 2.907676e-09
R254 x4 x253 2.178760e+03
C255 x253 x5 3.390607e-09
R257 x4 x256 1.955233e+03
C258 x256 x5 2.574078e-09
R260 x4 x259 1.045959e+03
C261 x259 x5 3.278225e-09
R263 x4 x262 1.050530e+03
C264 x262 x5 2.223712e-09
R266 x4 x265 4.940707e+02
C267 x265 x5 3.221299e-09
R269 x4 x268 5.873357e+02
C270 x268 x5 1.846150e-09
R272 x4 x271 2.288991e+02
C273 x271 x5 3.227325e-09
R275 x4 x274 3.511423e+02
C276 x274 x5 1.433300e-09
R278 x4 x277 1.039779e+02
C279 x277 x5 3.297709e-09
R281 x4 x280 2.359181e+02
C282 x280 x5 9.902060e-10
R284 x4 x283 4.668160e+01
C285 x283 x5 3.409372e-09
R287 x4 x286 1.918782e+02
C288 x286 x5 5.651032e-10
R290 x4 x289 2.130159e+01
C291 x289 x5 3.467965e-09
R293 x4 x292 1.586679e+02
C294 x292 x5 3.171984e-10
R296 x4 x295 1.064569e+01
C297 x295 x5 3.220918e-09
R299 x4 x298 3.880345e+01
C300 x298 x5 6.020277e-10
R302 x4 x301 7.114660e+00
C303 x301 x5 2.237000e-09
R305 x4 x304 6.055940e+00
C306 x304 x5 1.790490e-09
R308 x4 x307 1.469873e+01
C309 x307 x5 5.025820e-10
R311 x4 x310 1.635467e+00
C312 x310 x5 3.077359e-09
R314 x4 x313 1.391201e+00
C315 x313 x5 1.679178e-09
R317 x4 x316 6.524621e-01
C318 x316 x5 2.439298e-09
R320 x4 x319 2.924578e+00
C321 x319 x5 2.525943e-10
R323 x4 x322 1.148088e-01
C324 x322 x5 4.383741e-09
R326 x4 x325 5.649850e-04
C327 x325 x5 2.816977e-08
R328 x5 B 3.500000e+02 ; wrist-to-trunk tissue
C329 B 0 3.541600e-11 ; watch ground + strap to wrist
C330 B E 1.400000e-10 ; her body to surroundings
C331 0 E 1.095445e-12 ; watch return path
C332 A E 1.400000e-10 ; his body to surroundings
R335 B x333 7.302967e+04 ; her skin, 60 cm^2
* CPE Q=5.2957e-06 alpha=0.900 her skin
R337 B x336 7.585850e+05
C338 x336 x333 3.079517e-07
R340 B x339 1.837994e+05
C341 x339 x333 8.659164e-07
R343 B x342 9.063774e+04
C344 x342 x333 3.783070e-07
R346 B x345 7.623273e+06
C347 x345 x333 3.064399e-09
R349 B x348 8.548089e+04
C350 x348 x333 1.861877e-07
R352 B x351 1.017131e+05
C353 x351 x333 1.066047e-07
R355 B x354 5.634330e+04
C356 x354 x333 1.311126e-07
R358 B x357 4.442773e+04
C359 x357 x333 1.132833e-07
R361 B x360 2.953481e+04
C362 x360 x333 1.160966e-07
R364 B x363 2.182383e+04
C365 x363 x333 1.070424e-07
R367 B x366 1.492633e+04
C368 x366 x333 1.066270e-07
R370 B x369 1.090058e+04
C371 x369 x333 9.947265e-08
R373 B x372 7.484357e+03
C374 x372 x333 9.870344e-08
R376 B x375 5.471495e+03
C377 x375 x333 9.198438e-08
R379 B x378 3.739688e+03
C380 x378 x333 9.168917e-08
R382 B x381 2.755140e+03
C383 x381 x333 8.478970e-08
R385 B x384 1.862966e+03
C386 x384 x333 8.543096e-08
R388 B x387 1.392143e+03
C389 x387 x333 7.788783e-08
R391 B x390 9.246970e+02
C392 x390 x333 7.988907e-08
R394 B x393 7.067099e+02
C395 x393 x333 7.121622e-08
R397 B x396 4.567522e+02
C398 x396 x333 7.507111e-08
R400 B x399 3.611765e+02
C401 x399 x333 6.467960e-08
R403 B x402 2.241002e+02
C404 x402 x333 7.101955e-08
R406 B x405 1.864565e+02
C407 x405 x333 5.815352e-08
R409 B x408 1.089380e+02
C410 x408 x333 6.781213e-08
R412 B x411 9.776163e+01
C413 x411 x333 5.148156e-08
R415 B x414 5.229795e+01
C416 x414 x333 6.556451e-08
R418 B x417 5.252649e+01
C419 x417 x333 4.447423e-08
R421 B x420 2.470353e+01
C422 x420 x333 6.442598e-08
R424 B x423 2.936679e+01
C425 x423 x333 3.692301e-08
R427 B x426 1.144496e+01
C428 x426 x333 6.454650e-08
R430 B x429 1.755711e+01
C431 x429 x333 2.866599e-08
R433 B x432 5.198896e+00
C434 x432 x333 6.595418e-08
R436 B x435 1.179590e+01
C437 x435 x333 1.980412e-08
R439 B x438 2.334080e+00
C440 x438 x333 6.818744e-08
R442 B x441 9.593912e+00
C443 x441 x333 1.130206e-08
R445 B x444 1.065080e+00
C446 x444 x333 6.935930e-08
R448 B x447 7.933397e+00
C449 x447 x333 6.343967e-09
R451 B x450 5.322845e-01
C452 x450 x333 6.441836e-08
R454 B x453 1.940172e+00
C455 x453 x333 1.204055e-08
R457 B x456 3.557330e-01
C458 x456 x333 4.474000e-08
R460 B x459 3.027970e-01
C461 x459 x333 3.580980e-08
R463 B x462 7.349366e-01
C464 x462 x333 1.005164e-08
R466 B x465 8.177337e-02
C467 x465 x333 6.154719e-08
R469 B x468 6.956007e-02
C470 x468 x333 3.358357e-08
R472 B x471 3.262310e-02
C473 x471 x333 4.878596e-08
R475 B x474 1.462289e-01
C476 x474 x333 5.051887e-09
R478 B x477 5.740441e-03
C479 x477 x333 8.767482e-08
R481 B x480 2.824925e-05
C482 x480 x333 5.633953e-07
C483 x333 x334 3.015146e-10 ; fabric
R484 x334 A 7.302967e+04 ; his skin, 60 cm^2
* CPE Q=5.2957e-06 alpha=0.900 his skin
R486 x334 x485 7.585850e+05
C487 x485 A 3.079517e-07
R489 x334 x488 1.837994e+05
C490 x488 A 8.659164e-07
R492 x334 x491 9.063774e+04
C493 x491 A 3.783070e-07
R495 x334 x494 7.623273e+06
C496 x494 A 3.064399e-09
R498 x334 x497 8.548089e+04
C499 x497 A 1.861877e-07
R501 x334 x500 1.017131e+05
C502 x500 A 1.066047e-07
R504 x334 x503 5.634330e+04
C505 x503 A 1.311126e-07
R507 x334 x506 4.442773e+04
C508 x506 A 1.132833e-07
R510 x334 x509 2.953481e+04
C511 x509 A 1.160966e-07
R513 x334 x512 2.182383e+04
C514 x512 A 1.070424e-07
R516 x334 x515 1.492633e+04
C517 x515 A 1.066270e-07
R519 x334 x518 1.090058e+04
C520 x518 A 9.947265e-08
R522 x334 x521 7.484357e+03
C523 x521 A 9.870344e-08
R525 x334 x524 5.471495e+03
C526 x524 A 9.198438e-08
R528 x334 x527 3.739688e+03
C529 x527 A 9.168917e-08
R531 x334 x530 2.755140e+03
C532 x530 A 8.478970e-08
R534 x334 x533 1.862966e+03
C535 x533 A 8.543096e-08
R537 x334 x536 1.392143e+03
C538 x536 A 7.788783e-08
R540 x334 x539 9.246970e+02
C541 x539 A 7.988907e-08
R543 x334 x542 7.067099e+02
C544 x542 A 7.121622e-08
R546 x334 x545 4.567522e+02
C547 x545 A 7.507111e-08
R549 x334 x548 3.611765e+02
C550 x548 A 6.467960e-08
R552 x334 x551 2.241002e+02
C553 x551 A 7.101955e-08
R555 x334 x554 1.864565e+02
C556 x554 A 5.815352e-08
R558 x334 x557 1.089380e+02
C559 x557 A 6.781213e-08
R561 x334 x560 9.776163e+01
C562 x560 A 5.148156e-08
R564 x334 x563 5.229795e+01
C565 x563 A 6.556451e-08
R567 x334 x566 5.252649e+01
C568 x566 A 4.447423e-08
R570 x334 x569 2.470353e+01
C571 x569 A 6.442598e-08
R573 x334 x572 2.936679e+01
C574 x572 A 3.692301e-08
R576 x334 x575 1.144496e+01
C577 x575 A 6.454650e-08
R579 x334 x578 1.755711e+01
C580 x578 A 2.866599e-08
R582 x334 x581 5.198896e+00
C583 x581 A 6.595418e-08
R585 x334 x584 1.179590e+01
C586 x584 A 1.980412e-08
R588 x334 x587 2.334080e+00
C589 x587 A 6.818744e-08
R591 x334 x590 9.593912e+00
C592 x590 A 1.130206e-08
R594 x334 x593 1.065080e+00
C595 x593 A 6.935930e-08
R597 x334 x596 7.933397e+00
C598 x596 A 6.343967e-09
R600 x334 x599 5.322845e-01
C601 x599 A 6.441836e-08
R603 x334 x602 1.940172e+00
C604 x602 A 1.204055e-08
R606 x334 x605 3.557330e-01
C607 x605 A 4.474000e-08
R609 x334 x608 3.027970e-01
C610 x608 A 3.580980e-08
R612 x334 x611 7.349366e-01
C613 x611 A 1.005164e-08
R615 x334 x614 8.177337e-02
C616 x614 A 6.154719e-08
R618 x334 x617 6.956007e-02
C619 x617 A 3.358357e-08
R621 x334 x620 3.262310e-02
C622 x620 A 4.878596e-08
R624 x334 x623 1.462289e-01
C625 x623 A 5.051887e-09
R627 x334 x626 5.740441e-03
C628 x626 A 8.767482e-08
R630 x334 x629 2.824925e-05
C631 x629 A 5.633953e-07
C632 A 0 1.204990e-13 ; his body to the watch
.options rshunt=1e18
.end
