* SparshaGuard v0.3 | dual_shield | street_shoes | other_person wrist | bench=False
* nodes: S sense, B her body, A other person, E surroundings, 0 watch ground
V1 drv 0 AC 1
R1 drv n1 1.000000e+04 ; Rs
L2 n1 S 1.000000e-02 ; tank inductor
C3 S 0 1.045000e-10 ; tank C + buffer/trace parasitics
* CPE Q=4.2894e-07 alpha=0.550 metal contact
R7 S x6 3.961284e+06
C8 x6 x4 2.737269e-07
R10 S x9 3.540280e+06
C11 x9 x4 2.086648e-07
R13 S x12 1.198970e+07
C14 x12 x4 1.327431e-08
R16 S x15 2.251156e+06
C17 x15 x4 4.816680e-08
R19 S x18 5.528439e+07
C20 x18 x4 1.336239e-09
R22 S x21 2.920103e+06
C23 x21 x4 1.723542e-08
R25 S x24 3.200242e+06
C26 x24 x4 1.071447e-08
R28 S x27 2.426108e+06
C29 x27 x4 9.628899e-09
R31 S x30 1.984652e+06
C32 x30 x4 8.019285e-09
R34 S x33 1.604297e+06
C35 x33 x4 6.758788e-09
R37 S x36 1.299485e+06
C38 x36 x4 5.684805e-09
R40 S x39 1.052103e+06
C41 x39 x4 4.783676e-09
R43 S x42 8.519455e+05
C44 x42 x4 4.024775e-09
R46 S x45 6.898161e+05
C47 x45 x4 3.386519e-09
R49 S x48 5.585671e+05
C50 x48 x4 2.849343e-09
R52 S x51 4.522736e+05
C53 x51 x4 2.397465e-09
R55 S x54 3.662197e+05
C56 x54 x4 2.017182e-09
R58 S x57 2.965293e+05
C59 x57 x4 1.697276e-09
R61 S x60 2.401093e+05
C62 x60 x4 1.428053e-09
R64 S x63 1.944166e+05
C65 x63 x4 1.201582e-09
R67 S x66 1.574262e+05
C68 x66 x4 1.010981e-09
R70 S x69 1.274671e+05
C71 x69 x4 8.506586e-10
R73 S x72 1.032158e+05
C74 x72 x4 7.157161e-10
R76 S x75 8.357224e+04
C77 x75 x4 6.022241e-10
R79 S x78 6.767311e+04
C80 x78 x4 5.066842e-10
R82 S x81 5.479293e+04
C83 x81 x4 4.263461e-10
R85 S x84 4.436984e+04
C86 x84 x4 3.587007e-10
R88 S x87 3.592402e+04
C89 x87 x4 3.018343e-10
R91 S x90 2.909123e+04
C92 x90 x4 2.539362e-10
R94 S x93 2.355279e+04
C95 x93 x4 2.136868e-10
R97 S x96 1.907392e+04
C98 x96 x4 1.797685e-10
R100 S x99 1.544171e+04
C101 x99 x4 1.512834e-10
R103 S x102 1.250613e+04
C104 x102 x4 1.272615e-10
R106 S x105 1.012377e+04
C107 x105 x4 1.071054e-10
R109 S x108 8.200000e+03
C110 x108 x4 9.008924e-11
R112 S x111 6.637121e+03
C113 x111 x4 7.582989e-11
R115 S x114 5.376702e+03
C116 x114 x4 6.377309e-11
R118 S x117 4.351144e+03
C119 x117 x4 5.368876e-11
R121 S x120 3.525614e+03
C122 x120 x4 4.514247e-11
R124 S x123 2.852377e+03
C125 x123 x4 3.801426e-11
R127 S x126 2.311949e+03
C128 x126 x4 3.195277e-11
R130 S x129 1.869736e+03
C131 x129 x4 2.691782e-11
R133 S x132 1.516207e+03
C134 x132 x4 2.261492e-11
R136 S x135 1.225488e+03
C137 x135 x4 1.906241e-11
R139 S x138 9.944741e+02
C140 x138 x4 1.600393e-11
R142 S x141 8.031032e+02
C143 x141 x4 1.350150e-11
R145 S x144 6.523900e+02
C146 x144 x4 1.132347e-11
R148 S x147 5.261973e+02
C149 x147 x4 9.564703e-12
R151 S x150 4.280423e+02
C152 x150 x4 8.010631e-12
R154 S x153 3.448148e+02
C155 x153 x4 6.774869e-12
R157 S x156 2.804654e+02
C158 x156 x4 5.674673e-12
R160 S x159 2.273532e+02
C161 x159 x4 4.769276e-12
R163 S x162 1.792005e+02
C164 x162 x4 4.122375e-12
R166 S x165 1.667349e+02
C167 x165 x4 3.018517e-12
R169 S x168 8.658586e+01
C170 x168 x4 3.960103e-12
R172 S x171 3.392456e+01
C173 x171 x4 4.691438e-12
R175 S x174 6.171394e+01
C176 x174 x4 1.756994e-12
R178 S x177 2.029061e+00
C179 x177 x4 7.843774e-12
R180 x4 x5 1.460593e+06 ; stratum corneum, 3 cm^2
* CPE Q=2.6478e-07 alpha=0.900 stratum corneum
R182 x4 x181 1.517170e+07
C183 x181 x5 1.539758e-08
R185 x4 x184 3.675989e+06
C186 x184 x5 4.329582e-08
R188 x4 x187 1.812755e+06
C189 x187 x5 1.891535e-08
R191 x4 x190 1.524655e+08
C192 x190 x5 1.532200e-10
R194 x4 x193 1.709618e+06
C195 x193 x5 9.309387e-09
R197 x4 x196 2.034262e+06
C198 x196 x5 5.330237e-09
R200 x4 x199 1.126866e+06
C201 x199 x5 6.555632e-09
R203 x4 x202 8.885546e+05
C204 x202 x5 5.664166e-09
R206 x4 x205 5.906961e+05
C207 x205 x5 5.804828e-09
R209 x4 x208 4.364766e+05
C210 x208 x5 5.352120e-09
R212 x4 x211 2.985266e+05
C213 x211 x5 5.331348e-09
R215 x4 x214 2.180117e+05
C216 x214 x5 4.973633e-09
R218 x4 x217 1.496871e+05
C219 x217 x5 4.935172e-09
R221 x4 x220 1.094299e+05
C222 x220 x5 4.599219e-09
R224 x4 x223 7.479377e+04
C225 x223 x5 4.584458e-09
R227 x4 x226 5.510281e+04
C228 x226 x5 4.239485e-09
R230 x4 x229 3.725931e+04
C231 x229 x5 4.271548e-09
R233 x4 x232 2.784286e+04
C234 x232 x5 3.894391e-09
R236 x4 x235 1.849394e+04
C237 x235 x5 3.994454e-09
R239 x4 x238 1.413420e+04
C240 x238 x5 3.560811e-09
R242 x4 x241 9.135044e+03
C243 x241 x5 3.753555e-09
R245 x4 x244 7.223529e+03
C246 x244 x5 3.233980e-09
R248 x4 x247 4.482004e+03
C249 x247 x5 3.550977e-09
R251 x4 x250 3.729129e+03
C252 x250 x5 2.907676e-09
R254 x4 x253 2.178760e+03
C255 x253 x5 3.390607e-09
R257 x4 x256 1.955233e+03
C258 x256 x5 2.574078e-09
R260 x4 x259 1.045959e+03
C261 x259 x5 3.278225e-09
R263 x4 x262 1.050530e+03
C264 x262 x5 2.223712e-09
R266 x4 x265 4.940707e+02
C267 x265 x5 3.221299e-09
R269 x4 x268 5.873357e+02
C270 x268 x5 1.846150e-09
R272 x4 x271 2.288991e+02
C273 x271 x5 3.227325e-09
R275 x4 x274 3.511423e+02
C276 x274 x5 1.433300e-09
R278 x4 x277 1.039779e+02
C279 x277 x5 3.297709e-09
R281 x4 x280 2.359181e+02
C282 x280 x5 9.902060e-10
R284 x4 x283 4.668160e+01
C285 x283 x5 3.409372e-09
R287 x4 x286 1.918782e+02
C288 x286 x5 5.651032e-10
R290 x4 x289 2.130159e+01
C291 x289 x5 3.467965e-09
R293 x4 x292 1.586679e+02
C294 x292 x5 3.171984e-10
R296 x4 x295 1.064569e+01
C297 x295 x5 3.220918e-09
R299 x4 x298 3.880345e+01
C300 x298 x5 6.020277e-10
R302 x4 x301 7.114660e+00
C303 x301 x5 2.237000e-09
R305 x4 x304 6.055940e+00
C306 x304 x5 1.790490e-09
R308 x4 x307 1.469873e+01
C309 x307 x5 5.025820e-10
R311 x4 x310 1.635467e+00
C312 x310 x5 3.077359e-09
R314 x4 x313 1.391201e+00
C315 x313 x5 1.679178e-09
R317 x4 x316 6.524621e-01
C318 x316 x5 2.439298e-09
R320 x4 x319 2.924578e+00
C321 x319 x5 2.525943e-10
R323 x4 x322 1.148088e-01
C324 x322 x5 4.383741e-09
R326 x4 x325 5.649850e-04
C327 x325 x5 2.816977e-08
R328 x5 B 3.500000e+02 ; wrist-to-trunk tissue
C329 B 0 1.239560e-11 ; watch ground + strap to wrist
C330 B E 1.400000e-10 ; her body to surroundings
C331 0 E 1.095445e-12 ; watch return path
C332 A E 1.400000e-10 ; his body to surroundings
R334 B x333 7.302967e+04 ; her skin, 60 cm^2
* CPE Q=5.2957e-06 alpha=0.900 her skin
R336 B x335 7.585850e+05
C337 x335 x333 3.079517e-07
R339 B x338 1.837994e+05
C340 x338 x333 8.659164e-07
R342 B x341 9.063774e+04
C343 x341 x333 3.783070e-07
R345 B x344 7.623273e+06
C346 x344 x333 3.064399e-09
R348 B x347 8.548089e+04
C349 x347 x333 1.861877e-07
R351 B x350 1.017131e+05
C352 x350 x333 1.066047e-07
R354 B x353 5.634330e+04
C355 x353 x333 1.311126e-07
R357 B x356 4.442773e+04
C358 x356 x333 1.132833e-07
R360 B x359 2.953481e+04
C361 x359 x333 1.160966e-07
R363 B x362 2.182383e+04
C364 x362 x333 1.070424e-07
R366 B x365 1.492633e+04
C367 x365 x333 1.066270e-07
R369 B x368 1.090058e+04
C370 x368 x333 9.947265e-08
R372 B x371 7.484357e+03
C373 x371 x333 9.870344e-08
R375 B x374 5.471495e+03
C376 x374 x333 9.198438e-08
R378 B x377 3.739688e+03
C379 x377 x333 9.168917e-08
R381 B x380 2.755140e+03
C382 x380 x333 8.478970e-08
R384 B x383 1.862966e+03
C385 x383 x333 8.543096e-08
R387 B x386 1.392143e+03
C388 x386 x333 7.788783e-08
R390 B x389 9.246970e+02
C391 x389 x333 7.988907e-08
R393 B x392 7.067099e+02
C394 x392 x333 7.121622e-08
R396 B x395 4.567522e+02
C397 x395 x333 7.507111e-08
R399 B x398 3.611765e+02
C400 x398 x333 6.467960e-08
R402 B x401 2.241002e+02
C403 x401 x333 7.101955e-08
R405 B x404 1.864565e+02
C406 x404 x333 5.815352e-08
R408 B x407 1.089380e+02
C409 x407 x333 6.781213e-08
R411 B x410 9.776163e+01
C412 x410 x333 5.148156e-08
R414 B x413 5.229795e+01
C415 x413 x333 6.556451e-08
R417 B x416 5.252649e+01
C418 x416 x333 4.447423e-08
R420 B x419 2.470353e+01
C421 x419 x333 6.442598e-08
R423 B x422 2.936679e+01
C424 x422 x333 3.692301e-08
R426 B x425 1.144496e+01
C427 x425 x333 6.454650e-08
R429 B x428 1.755711e+01
C430 x428 x333 2.866599e-08
R432 B x431 5.198896e+00
C433 x431 x333 6.595418e-08
R435 B x434 1.179590e+01
C436 x434 x333 1.980412e-08
R438 B x437 2.334080e+00
C439 x437 x333 6.818744e-08
R441 B x440 9.593912e+00
C442 x440 x333 1.130206e-08
R444 B x443 1.065080e+00
C445 x443 x333 6.935930e-08
R447 B x446 7.933397e+00
C448 x446 x333 6.343967e-09
R450 B x449 5.322845e-01
C451 x449 x333 6.441836e-08
R453 B x452 1.940172e+00
C454 x452 x333 1.204055e-08
R456 B x455 3.557330e-01
C457 x455 x333 4.474000e-08
R459 B x458 3.027970e-01
C460 x458 x333 3.580980e-08
R462 B x461 7.349366e-01
C463 x461 x333 1.005164e-08
R465 B x464 8.177337e-02
C466 x464 x333 6.154719e-08
R468 B x467 6.956007e-02
C469 x467 x333 3.358357e-08
R471 B x470 3.262310e-02
C472 x470 x333 4.878596e-08
R474 B x473 1.462289e-01
C475 x473 x333 5.051887e-09
R477 B x476 5.740441e-03
C478 x476 x333 8.767482e-08
R480 B x479 2.824925e-05
C481 x479 x333 5.633953e-07
R482 x333 A 7.302967e+04 ; his skin, 60 cm^2
* CPE Q=5.2957e-06 alpha=0.900 his skin
R484 x333 x483 7.585850e+05
C485 x483 A 3.079517e-07
R487 x333 x486 1.837994e+05
C488 x486 A 8.659164e-07
R490 x333 x489 9.063774e+04
C491 x489 A 3.783070e-07
R493 x333 x492 7.623273e+06
C494 x492 A 3.064399e-09
R496 x333 x495 8.548089e+04
C497 x495 A 1.861877e-07
R499 x333 x498 1.017131e+05
C500 x498 A 1.066047e-07
R502 x333 x501 5.634330e+04
C503 x501 A 1.311126e-07
R505 x333 x504 4.442773e+04
C506 x504 A 1.132833e-07
R508 x333 x507 2.953481e+04
C509 x507 A 1.160966e-07
R511 x333 x510 2.182383e+04
C512 x510 A 1.070424e-07
R514 x333 x513 1.492633e+04
C515 x513 A 1.066270e-07
R517 x333 x516 1.090058e+04
C518 x516 A 9.947265e-08
R520 x333 x519 7.484357e+03
C521 x519 A 9.870344e-08
R523 x333 x522 5.471495e+03
C524 x522 A 9.198438e-08
R526 x333 x525 3.739688e+03
C527 x525 A 9.168917e-08
R529 x333 x528 2.755140e+03
C530 x528 A 8.478970e-08
R532 x333 x531 1.862966e+03
C533 x531 A 8.543096e-08
R535 x333 x534 1.392143e+03
C536 x534 A 7.788783e-08
R538 x333 x537 9.246970e+02
C539 x537 A 7.988907e-08
R541 x333 x540 7.067099e+02
C542 x540 A 7.121622e-08
R544 x333 x543 4.567522e+02
C545 x543 A 7.507111e-08
R547 x333 x546 3.611765e+02
C548 x546 A 6.467960e-08
R550 x333 x549 2.241002e+02
C551 x549 A 7.101955e-08
R553 x333 x552 1.864565e+02
C554 x552 A 5.815352e-08
R556 x333 x555 1.089380e+02
C557 x555 A 6.781213e-08
R559 x333 x558 9.776163e+01
C560 x558 A 5.148156e-08
R562 x333 x561 5.229795e+01
C563 x561 A 6.556451e-08
R565 x333 x564 5.252649e+01
C566 x564 A 4.447423e-08
R568 x333 x567 2.470353e+01
C569 x567 A 6.442598e-08
R571 x333 x570 2.936679e+01
C572 x570 A 3.692301e-08
R574 x333 x573 1.144496e+01
C575 x573 A 6.454650e-08
R577 x333 x576 1.755711e+01
C578 x576 A 2.866599e-08
R580 x333 x579 5.198896e+00
C581 x579 A 6.595418e-08
R583 x333 x582 1.179590e+01
C584 x582 A 1.980412e-08
R586 x333 x585 2.334080e+00
C587 x585 A 6.818744e-08
R589 x333 x588 9.593912e+00
C590 x588 A 1.130206e-08
R592 x333 x591 1.065080e+00
C593 x591 A 6.935930e-08
R595 x333 x594 7.933397e+00
C596 x594 A 6.343967e-09
R598 x333 x597 5.322845e-01
C599 x597 A 6.441836e-08
R601 x333 x600 1.940172e+00
C602 x600 A 1.204055e-08
R604 x333 x603 3.557330e-01
C605 x603 A 4.474000e-08
R607 x333 x606 3.027970e-01
C608 x606 A 3.580980e-08
R610 x333 x609 7.349366e-01
C611 x609 A 1.005164e-08
R613 x333 x612 8.177337e-02
C614 x612 A 6.154719e-08
R616 x333 x615 6.956007e-02
C617 x615 A 3.358357e-08
R619 x333 x618 3.262310e-02
C620 x618 A 4.878596e-08
R622 x333 x621 1.462289e-01
C623 x621 A 5.051887e-09
R625 x333 x624 5.740441e-03
C626 x624 A 8.767482e-08
R628 x333 x627 2.824925e-05
C629 x627 A 5.633953e-07
R631 A x630 2.921187e+05 ; palm skin, 15 cm^2
* CPE Q=1.3239e-06 alpha=0.900 palm skin
R633 A x632 3.034340e+06
C634 x632 x630 7.698792e-08
R636 A x635 7.351977e+05
C637 x635 x630 2.164791e-07
R639 A x638 3.625510e+05
C640 x638 x630 9.457675e-08
R642 A x641 3.049309e+07
C643 x641 x630 7.660998e-10
R645 A x644 3.419236e+05
C646 x644 x630 4.654693e-08
R648 A x647 4.068524e+05
C649 x647 x630 2.665119e-08
R651 A x650 2.253732e+05
C652 x650 x630 3.277816e-08
R654 A x653 1.777109e+05
C655 x653 x630 2.832083e-08
R657 A x656 1.181392e+05
C658 x656 x630 2.902414e-08
R660 A x659 8.729532e+04
C661 x659 x630 2.676060e-08
R663 A x662 5.970533e+04
C664 x662 x630 2.665674e-08
R666 A x665 4.360234e+04
C667 x665 x630 2.486816e-08
R669 A x668 2.993743e+04
C670 x668 x630 2.467586e-08
R672 A x671 2.188598e+04
C673 x671 x630 2.299610e-08
R675 A x674 1.495875e+04
C676 x674 x630 2.292229e-08
R678 A x677 1.102056e+04
C679 x677 x630 2.119742e-08
R681 A x680 7.451863e+03
C682 x680 x630 2.135774e-08
R684 A x683 5.568572e+03
C685 x683 x630 1.947196e-08
R687 A x686 3.698788e+03
C688 x686 x630 1.997227e-08
R690 A x689 2.826840e+03
C691 x689 x630 1.780406e-08
R693 A x692 1.827009e+03
C694 x692 x630 1.876778e-08
R696 A x695 1.444706e+03
C697 x695 x630 1.616990e-08
R699 A x698 8.964008e+02
C700 x698 x630 1.775489e-08
R702 A x701 7.458259e+02
C703 x701 x630 1.453838e-08
R705 A x704 4.357520e+02
C706 x704 x630 1.695303e-08
R708 A x707 3.910465e+02
C709 x707 x630 1.287039e-08
R711 A x710 2.091918e+02
C712 x710 x630 1.639113e-08
R714 A x713 2.101059e+02
C715 x713 x630 1.111856e-08
R717 A x716 9.881413e+01
C718 x716 x630 1.610650e-08
R720 A x719 1.174671e+02
C721 x719 x630 9.230752e-09
R723 A x722 4.577982e+01
C724 x722 x630 1.613662e-08
R726 A x725 7.022846e+01
C727 x725 x630 7.166498e-09
R729 A x728 2.079558e+01
C730 x728 x630 1.648855e-08
R732 A x731 4.718362e+01
C733 x731 x630 4.951030e-09
R735 A x734 9.336320e+00
C736 x734 x630 1.704686e-08
R738 A x737 3.837565e+01
C739 x737 x630 2.825516e-09
R741 A x740 4.260319e+00
C742 x740 x630 1.733982e-08
R744 A x743 3.173359e+01
C745 x743 x630 1.585992e-09
R747 A x746 2.129138e+00
C748 x746 x630 1.610459e-08
R750 A x749 7.760690e+00
C751 x749 x630 3.010138e-09
R753 A x752 1.422932e+00
C754 x752 x630 1.118500e-08
R756 A x755 1.211188e+00
C757 x755 x630 8.952450e-09
R759 A x758 2.939746e+00
C760 x758 x630 2.512910e-09
R762 A x761 3.270935e-01
C763 x761 x630 1.538680e-08
R765 A x764 2.782403e-01
C766 x764 x630 8.395892e-09
R768 A x767 1.304924e-01
C769 x767 x630 1.219649e-08
R771 A x770 5.849156e-01
C772 x770 x630 1.262972e-09
R774 A x773 2.296176e-02
C775 x773 x630 2.191871e-08
R777 A x776 1.129970e-04
C778 x776 x630 1.408488e-07
C779 x630 0 6.374880e-10 ; strap coating
.options rshunt=1e18
.end
