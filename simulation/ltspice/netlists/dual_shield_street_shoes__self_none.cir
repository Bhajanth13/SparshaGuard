* SparshaGuard v0.3 | dual_shield | street_shoes | self  | bench=False
* nodes: S sense, B her body, A other person, E surroundings, 0 watch ground
V1 drv 0 AC 1
R1 drv n1 1.000000e+04 ; Rs
L2 n1 S 1.000000e-02 ; tank inductor
C3 S 0 1.069500e-10 ; tank C + buffer/trace parasitics
* CPE Q=4.2894e-07 alpha=0.550 metal contact
R7 S x6 3.961284e+06
C8 x6 x4 2.737269e-07
R10 S x9 3.540280e+06
C11 x9 x4 2.086648e-07
R13 S x12 1.198970e+07
C14 x12 x4 1.327431e-08
R16 S x15 2.251156e+06
C17 x15 x4 4.816680e-08
R19 S x18 5.528439e+07
C20 x18 x4 1.336239e-09
R22 S x21 2.920103e+06
C23 x21 x4 1.723542e-08
R25 S x24 3.200242e+06
C26 x24 x4 1.071447e-08
R28 S x27 2.426108e+06
C29 x27 x4 9.628899e-09
R31 S x30 1.984652e+06
C32 x30 x4 8.019285e-09
R34 S x33 1.604297e+06
C35 x33 x4 6.758788e-09
R37 S x36 1.299485e+06
C38 x36 x4 5.684805e-09
R40 S x39 1.052103e+06
C41 x39 x4 4.783676e-09
R43 S x42 8.519455e+05
C44 x42 x4 4.024775e-09
R46 S x45 6.898161e+05
C47 x45 x4 3.386519e-09
R49 S x48 5.585671e+05
C50 x48 x4 2.849343e-09
R52 S x51 4.522736e+05
C53 x51 x4 2.397465e-09
R55 S x54 3.662197e+05
C56 x54 x4 2.017182e-09
R58 S x57 2.965293e+05
C59 x57 x4 1.697276e-09
R61 S x60 2.401093e+05
C62 x60 x4 1.428053e-09
R64 S x63 1.944166e+05
C65 x63 x4 1.201582e-09
R67 S x66 1.574262e+05
C68 x66 x4 1.010981e-09
R70 S x69 1.274671e+05
C71 x69 x4 8.506586e-10
R73 S x72 1.032158e+05
C74 x72 x4 7.157161e-10
R76 S x75 8.357224e+04
C77 x75 x4 6.022241e-10
R79 S x78 6.767311e+04
C80 x78 x4 5.066842e-10
R82 S x81 5.479293e+04
C83 x81 x4 4.263461e-10
R85 S x84 4.436984e+04
C86 x84 x4 3.587007e-10
R88 S x87 3.592402e+04
C89 x87 x4 3.018343e-10
R91 S x90 2.909123e+04
C92 x90 x4 2.539362e-10
R94 S x93 2.355279e+04
C95 x93 x4 2.136868e-10
R97 S x96 1.907392e+04
C98 x96 x4 1.797685e-10
R100 S x99 1.544171e+04
C101 x99 x4 1.512834e-10
R103 S x102 1.250613e+04
C104 x102 x4 1.272615e-10
R106 S x105 1.012377e+04
C107 x105 x4 1.071054e-10
R109 S x108 8.200000e+03
C110 x108 x4 9.008924e-11
R112 S x111 6.637121e+03
C113 x111 x4 7.582989e-11
R115 S x114 5.376702e+03
C116 x114 x4 6.377309e-11
R118 S x117 4.351144e+03
C119 x117 x4 5.368876e-11
R121 S x120 3.525614e+03
C122 x120 x4 4.514247e-11
R124 S x123 2.852377e+03
C125 x123 x4 3.801426e-11
R127 S x126 2.311949e+03
C128 x126 x4 3.195277e-11
R130 S x129 1.869736e+03
C131 x129 x4 2.691782e-11
R133 S x132 1.516207e+03
C134 x132 x4 2.261492e-11
R136 S x135 1.225488e+03
C137 x135 x4 1.906241e-11
R139 S x138 9.944741e+02
C140 x138 x4 1.600393e-11
R142 S x141 8.031032e+02
C143 x141 x4 1.350150e-11
R145 S x144 6.523900e+02
C146 x144 x4 1.132347e-11
R148 S x147 5.261973e+02
C149 x147 x4 9.564703e-12
R151 S x150 4.280423e+02
C152 x150 x4 8.010631e-12
R154 S x153 3.448148e+02
C155 x153 x4 6.774869e-12
R157 S x156 2.804654e+02
C158 x156 x4 5.674673e-12
R160 S x159 2.273532e+02
C161 x159 x4 4.769276e-12
R163 S x162 1.792005e+02
C164 x162 x4 4.122375e-12
R166 S x165 1.667349e+02
C167 x165 x4 3.018517e-12
R169 S x168 8.658586e+01
C170 x168 x4 3.960103e-12
R172 S x171 3.392456e+01
C173 x171 x4 4.691438e-12
R175 S x174 6.171394e+01
C176 x174 x4 1.756994e-12
R178 S x177 2.029061e+00
C179 x177 x4 7.843774e-12
R180 x4 x5 1.460593e+06 ; stratum corneum, 3 cm^2
* CPE Q=2.6478e-07 alpha=0.900 stratum corneum
R182 x4 x181 1.517170e+07
C183 x181 x5 1.539758e-08
R185 x4 x184 3.675989e+06
C186 x184 x5 4.329582e-08
R188 x4 x187 1.812755e+06
C189 x187 x5 1.891535e-08
R191 x4 x190 1.524655e+08
C192 x190 x5 1.532200e-10
R194 x4 x193 1.709618e+06
C195 x193 x5 9.309387e-09
R197 x4 x196 2.034262e+06
C198 x196 x5 5.330237e-09
R200 x4 x199 1.126866e+06
C201 x199 x5 6.555632e-09
R203 x4 x202 8.885546e+05
C204 x202 x5 5.664166e-09
R206 x4 x205 5.906961e+05
C207 x205 x5 5.804828e-09
R209 x4 x208 4.364766e+05
C210 x208 x5 5.352120e-09
R212 x4 x211 2.985266e+05
C213 x211 x5 5.331348e-09
R215 x4 x214 2.180117e+05
C216 x214 x5 4.973633e-09
R218 x4 x217 1.496871e+05
C219 x217 x5 4.935172e-09
R221 x4 x220 1.094299e+05
C222 x220 x5 4.599219e-09
R224 x4 x223 7.479377e+04
C225 x223 x5 4.584458e-09
R227 x4 x226 5.510281e+04
C228 x226 x5 4.239485e-09
R230 x4 x229 3.725931e+04
C231 x229 x5 4.271548e-09
R233 x4 x232 2.784286e+04
C234 x232 x5 3.894391e-09
R236 x4 x235 1.849394e+04
C237 x235 x5 3.994454e-09
R239 x4 x238 1.413420e+04
C240 x238 x5 3.560811e-09
R242 x4 x241 9.135044e+03
C243 x241 x5 3.753555e-09
R245 x4 x244 7.223529e+03
C246 x244 x5 3.233980e-09
R248 x4 x247 4.482004e+03
C249 x247 x5 3.550977e-09
R251 x4 x250 3.729129e+03
C252 x250 x5 2.907676e-09
R254 x4 x253 2.178760e+03
C255 x253 x5 3.390607e-09
R257 x4 x256 1.955233e+03
C258 x256 x5 2.574078e-09
R260 x4 x259 1.045959e+03
C261 x259 x5 3.278225e-09
R263 x4 x262 1.050530e+03
C264 x262 x5 2.223712e-09
R266 x4 x265 4.940707e+02
C267 x265 x5 3.221299e-09
R269 x4 x268 5.873357e+02
C270 x268 x5 1.846150e-09
R272 x4 x271 2.288991e+02
C273 x271 x5 3.227325e-09
R275 x4 x274 3.511423e+02
C276 x274 x5 1.433300e-09
R278 x4 x277 1.039779e+02
C279 x277 x5 3.297709e-09
R281 x4 x280 2.359181e+02
C282 x280 x5 9.902060e-10
R284 x4 x283 4.668160e+01
C285 x283 x5 3.409372e-09
R287 x4 x286 1.918782e+02
C288 x286 x5 5.651032e-10
R290 x4 x289 2.130159e+01
C291 x289 x5 3.467965e-09
R293 x4 x292 1.586679e+02
C294 x292 x5 3.171984e-10
R296 x4 x295 1.064569e+01
C297 x295 x5 3.220918e-09
R299 x4 x298 3.880345e+01
C300 x298 x5 6.020277e-10
R302 x4 x301 7.114660e+00
C303 x301 x5 2.237000e-09
R305 x4 x304 6.055940e+00
C306 x304 x5 1.790490e-09
R308 x4 x307 1.469873e+01
C309 x307 x5 5.025820e-10
R311 x4 x310 1.635467e+00
C312 x310 x5 3.077359e-09
R314 x4 x313 1.391201e+00
C315 x313 x5 1.679178e-09
R317 x4 x316 6.524621e-01
C318 x316 x5 2.439298e-09
R320 x4 x319 2.924578e+00
C321 x319 x5 2.525943e-10
R323 x4 x322 1.148088e-01
C324 x322 x5 4.383741e-09
R326 x4 x325 5.649850e-04
C327 x325 x5 2.816977e-08
R328 x5 B 3.500000e+02 ; wrist-to-trunk tissue
C329 B 0 1.239560e-11 ; watch ground + strap to wrist
C330 B E 1.400000e-10 ; her body to surroundings
C331 0 E 1.095445e-12 ; watch return path
C332 A E 1.400000e-10 ; his body to surroundings
R335 0 x334 2.921187e+05 ; palm skin, 15 cm^2
* CPE Q=1.3239e-06 alpha=0.900 palm skin
R337 0 x336 3.034340e+06
C338 x336 x334 7.698792e-08
R340 0 x339 7.351977e+05
C341 x339 x334 2.164791e-07
R343 0 x342 3.625510e+05
C344 x342 x334 9.457675e-08
R346 0 x345 3.049309e+07
C347 x345 x334 7.660998e-10
R349 0 x348 3.419236e+05
C350 x348 x334 4.654693e-08
R352 0 x351 4.068524e+05
C353 x351 x334 2.665119e-08
R355 0 x354 2.253732e+05
C356 x354 x334 3.277816e-08
R358 0 x357 1.777109e+05
C359 x357 x334 2.832083e-08
R361 0 x360 1.181392e+05
C362 x360 x334 2.902414e-08
R364 0 x363 8.729532e+04
C365 x363 x334 2.676060e-08
R367 0 x366 5.970533e+04
C368 x366 x334 2.665674e-08
R370 0 x369 4.360234e+04
C371 x369 x334 2.486816e-08
R373 0 x372 2.993743e+04
C374 x372 x334 2.467586e-08
R376 0 x375 2.188598e+04
C377 x375 x334 2.299610e-08
R379 0 x378 1.495875e+04
C380 x378 x334 2.292229e-08
R382 0 x381 1.102056e+04
C383 x381 x334 2.119742e-08
R385 0 x384 7.451863e+03
C386 x384 x334 2.135774e-08
R388 0 x387 5.568572e+03
C389 x387 x334 1.947196e-08
R391 0 x390 3.698788e+03
C392 x390 x334 1.997227e-08
R394 0 x393 2.826840e+03
C395 x393 x334 1.780406e-08
R397 0 x396 1.827009e+03
C398 x396 x334 1.876778e-08
R400 0 x399 1.444706e+03
C401 x399 x334 1.616990e-08
R403 0 x402 8.964008e+02
C404 x402 x334 1.775489e-08
R406 0 x405 7.458259e+02
C407 x405 x334 1.453838e-08
R409 0 x408 4.357520e+02
C410 x408 x334 1.695303e-08
R412 0 x411 3.910465e+02
C413 x411 x334 1.287039e-08
R415 0 x414 2.091918e+02
C416 x414 x334 1.639113e-08
R418 0 x417 2.101059e+02
C419 x417 x334 1.111856e-08
R421 0 x420 9.881413e+01
C422 x420 x334 1.610650e-08
R424 0 x423 1.174671e+02
C425 x423 x334 9.230752e-09
R427 0 x426 4.577982e+01
C428 x426 x334 1.613662e-08
R430 0 x429 7.022846e+01
C431 x429 x334 7.166498e-09
R433 0 x432 2.079558e+01
C434 x432 x334 1.648855e-08
R436 0 x435 4.718362e+01
C437 x435 x334 4.951030e-09
R439 0 x438 9.336320e+00
C440 x438 x334 1.704686e-08
R442 0 x441 3.837565e+01
C443 x441 x334 2.825516e-09
R445 0 x444 4.260319e+00
C446 x444 x334 1.733982e-08
R448 0 x447 3.173359e+01
C449 x447 x334 1.585992e-09
R451 0 x450 2.129138e+00
C452 x450 x334 1.610459e-08
R454 0 x453 7.760690e+00
C455 x453 x334 3.010138e-09
R457 0 x456 1.422932e+00
C458 x456 x334 1.118500e-08
R460 0 x459 1.211188e+00
C461 x459 x334 8.952450e-09
R463 0 x462 2.939746e+00
C464 x462 x334 2.512910e-09
R466 0 x465 3.270935e-01
C467 x465 x334 1.538680e-08
R469 0 x468 2.782403e-01
C470 x468 x334 8.395892e-09
R472 0 x471 1.304924e-01
C473 x471 x334 1.219649e-08
R475 0 x474 5.849156e-01
C476 x474 x334 1.262972e-09
R478 0 x477 2.296176e-02
C479 x477 x334 2.191871e-08
R481 0 x480 1.129970e-04
C482 x480 x334 1.408488e-07
C483 x334 x333 6.162384e-10 ; strap coating
R484 x333 B 5.000000e+02 ; her two arm segments
.options rshunt=1e18
.end
